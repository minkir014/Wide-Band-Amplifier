ADE simulation setup
Run mode: Single Run, Sweeps and Corners
Tests:
  freq_rep:diff_req:1: freq_rep/diff_req/schematic, simulator spectre
Global variables:
  LP = 1u
  RS = 12k
  VDC = 2
  WP = 200u
  CCoupling = 10u
